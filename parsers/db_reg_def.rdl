// debug registers added in
regfile db_regs {
    reg { regwidth = 64; field {sw=r;} ADDR[63:0] = 0x0;} err_addr;
    reg { field {} CNT[31:0] = 0x63;} tmr_thr;
    reg {
        field { sw=r; } ERR_TYPE[3:2]       = 0x0;
        field { sw=rw; } ERR_OCCUR[1:1]     = 0x0;
        field { sw=rw; } SOFT_RST[0:0]      = 0x0;
    } err_stat;
};