// debug registers added in
regfile db_regs {
    reg { regwidth = 64; field {sw=r;} ADDR[63:0] = 0x0;} db_err_addr;
    reg { field {} CNT[31:0] = 0x63;} db_tmr_thr;
    reg {
        field { sw=r; } ERR_ACC_TYPE[2:2]   = 0x0;
        field { sw=rw; } ERR_OCCUR[1:1]     = 0x0;
        field { sw=rw; } SOFT_RST[0:0]      = 0x0;
    } db_err_stat;
};