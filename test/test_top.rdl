addrmap ddrc {
    hj_genmst = true;
    addrmap {
        hj_gendisp = true;
        addrmap {
            hj_genslv = true;
            reg {
                field {sw=rw;} rsvd = 0x0;
            } test[100];
        } ddrc;
    } ddrc;
    db_regs db_regs %= 0x1000;
};

// separate top-level addrmap of the whole register network
addrmap reg_network {
    hj_gennetwork = true;
    // register tree: root node ddrc contains ddrc and pcie registers
    ddrc ddrc @0x20000000;
};
