signal {
	name = "global_reset";
	desc = "Default";
	activehigh;
} global_reset;

addrmap module_unnamed{
	regfile {
		name = "template1";
		desc = "Default";

		external reg {
			name = "TEMPLATE寄存器";
			desc = "示例寄存器";
			regwidth = 32;

			field {
				name = "FIELD_1";
				desc = "[功能描述]...";
				sw = r;
				onread = rclr;
				
				resetsignal = global_reset;
			} FIELD_1[17:17] = 0x0;

			field {
				name = "FIELD_2";
				desc = "[功能描述]...";
				sw = rw;
				onread = rset;
				onwrite = woset;
				resetsignal = global_reset;
			} FIELD_2[16:14] = 0x0;

			field {
				name = "FIELD_3";
				desc = "[功能描述]...";
				sw = rw;
				onread = ruser;
				onwrite = wot;
				resetsignal = global_reset;
			} FIELD_3[13:13] = 0x1;

		} TEM1 @0x0;

		reg {
			name = "TEMPLATE寄存器";
			desc = "示例寄存器";
			regwidth = 32;

			field {
				name = "FIELD_1";
				desc = "[功能描述]...";
				sw = r;
				onread = rclr;
				
				resetsignal = global_reset;
			} FIELD_1[17:17] = 0x0;

			field {
				name = "FIELD_2";
				desc = "[功能描述]...";
				sw = rw;
				onread = rset;
				onwrite = woset;
				resetsignal = global_reset;
			} FIELD_2[16:14] = 0x0;

			field {
				name = "FIELD_3";
				desc = "[功能描述]...";
				sw = rw;
				
				onwrite = wot;
				resetsignal = global_reset;
			} FIELD_3[13:13] = 0x1;

		} TEM2 @0x4;

	} template1;

	regfile {
		name = "template2";
		desc = "Default";

		reg {
			name = "TEMPLATE寄存器";
			desc = "示例寄存器";
			regwidth = 32;

			field {
				name = "FIELD_1";
				desc = "[功能描述]...";
				sw = r;
				onread = rclr;
				
				resetsignal = global_reset;
			} FIELD_1[17:17] = 0x0;

			field {
				name = "FIELD_2";
				desc = "[功能描述]...";
				sw = rw;
				onread = rset;
				onwrite = woset;
				resetsignal = global_reset;
			} FIELD_2[16:14] = 0x0;

			field {
				name = "FIELD_3";
				desc = "[功能描述]...";
				sw = rw;
				
				onwrite = wot;
				resetsignal = global_reset;
			} FIELD_3[13:13] = 0x1;

		} TEM1 @0x0;

		reg {
			name = "TEMPLATE寄存器";
			desc = "示例寄存器";
			regwidth = 32;

			field {
				name = "FIELD_1";
				desc = "[功能描述]...";
				sw = r;
				onread = rclr;
				
				resetsignal = global_reset;
			} FIELD_1[17:17] = 0x0;

			field {
				name = "FIELD_2";
				desc = "[功能描述]...";
				sw = rw;
				onread = rset;
				onwrite = woset;
				resetsignal = global_reset;
			} FIELD_2[16:14] = 0x0;

			field {
				name = "FIELD_3";
				desc = "[功能描述]...";
				sw = rw;
				
				onwrite = wot;
				resetsignal = global_reset;
			} FIELD_3[13:13] = 0x1;

		} TEM2 @0x4;

	} template2;

};