addrmap root_map {
    base_addr = 0x20000000;
	hj_gendisp = true;
    reg tem_alias_1{
        regwidth = 64;
        field {} FIELD_1[17:17];
        field {} FIELD_2[16:14] = 0x0;
        field {swacc;swmod;} FIELD_3[13:13] = 0x1;
    };
    reg tem_alias_2{
        field {} FIELD_1[17:17] = 0x0;
        field {} FIELD_2[16:14] = 0x0;
        field {} FIELD_3[13:13] = 0x1;
    };
    addrmap flatten_map {
        hj_flatten_addrmap = true;

        tem_alias_1 TEM21;
        alias TEM21 tem_alias_1 TEM21_alias;

        tem_alias_2 TEM22;
        alias TEM22 tem_alias_2 TEM22_alias;
    };
	addrmap {
		hj_gendisp = true;
		addrmap {
			hj_genslv = true;
            hj_cdc = true;
			flatten_map map_11[5];
			flatten_map map_12[10];
		} slv_map;
	} disp_map;
};