addrmap root_map {
    base_addr = 0x20000000;
    hj_gendisp = true;
    reg tem_alias_1{
        field {hw=w;} FIELD_1[17:17] = 0x0;
        field {hw=w;} FIELD_2[16:14] = 0x0;
        field {hw=w;} FIELD_3[13:13] = 0x1;
    };
    reg tem_alias_2{
        field {hw=w;} FIELD_1[17:17] = 0x0;
        field {hw=w;} FIELD_2[16:14] = 0x0;
        field {hw=w;} FIELD_3[13:13] = 0x1;
    };
    addrmap flatten_map {
        hj_flatten_addrmap = true;

        tem_alias_1 TEM21 @0xc;
        alias TEM21 tem_alias_1 TEM21_alias @0x10c;

        tem_alias_2 TEM22 @0x10;
        alias TEM22 tem_alias_2 TEM22_alias @0x110;
    };
    addrmap {
        hj_gendisp = true;
        addrmap {
            hj_genslv = true;
            hj_cdc = true;
            flatten_map map_11[5];
            flatten_map map_12[10];
        } slv_map;
    } disp_map;
};