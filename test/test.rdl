// generated by HRDA tool

// this is an addrmap definition
// it will be instantiated in the top-level (root) addrmap below and treated as regslv
// in order to generate a regslv module to implement internal registers, designers need assign:
// 		hj_gendisp = false;
//		hj_genslv = true;
//      hj_flatten_addrmap = false;
addrmap template_slv{
	hj_gendisp = false;
	hj_genslv = true;
	hj_flatten_addrmap = false;

	name = "template_slv";
	desc = "[Reserved for editing]";

	signal {
		name = "srst_10";
		desc = "[Reserved for editing]";
		activehigh;
	} srst_10;

    // register definitions start here
	reg TEM{
		name = "TEM";
		desc = "Template Register";
		regwidth = 32;
		shared;

        // field definitions start here
		field {
			name = "FIELD_1";
			desc = "[Reserved for editing]";
			sw = r; onread = rclr;
			hw = rw;
			hj_syncresetsignal = "srst_10";
		} FIELD_1[17:17] = 0x0;

		field {
			name = "FIELD_2";
			desc = "[Reserved for editing]";
			sw = rw; onread = rset; onwrite = woset;
			hw = rw; hwclr;
		} FIELD_2[16:14] = 0x0;

		field {
			name = "FIELD_3";
			desc = "[Reserved for editing]";
			sw = rw; onwrite = wot;
			hw = rw; hwset;
		} FIELD_3[13:13] = 0x1;
	};

	TEM TEM1 @0x0;
	TEM TEM2;
};

// at least three addrmap instances are needed
// this is the top-level addrmap, and it will be automatically treated as regmst
addrmap template_mst {
    // it is recommended to assign hj_genmst = true and hj_flatten_addrmap = false
	hj_genmst = true;
	hj_flatten_addrmap = false;
	// this is the second-level addrmap, and it will be automatically treated as regdisp
	addrmap {
        // it is recommended to assign hj_gendisp = true and hj_flatten_addrmap = false
		hj_gendisp = true;
		hj_flatten_addrmap = false;
		// instantiate an addrmap defined above to generate a regslv module,
        // or designers can define an addrmap here
		template_slv template_slv;
		ipxact_block_example ipxact_map @0x200000000;
	} template_disp;
	// debug registers implemented in regmst, please don't touch it and keep this level clean
	db_regs db_regs %= 0x1000;
};
