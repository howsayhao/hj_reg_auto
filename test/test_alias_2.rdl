addrmap root_map {
	hj_genmst = true;
	hj_flatten_addrmap=false;
    reg tem_alias_1{
        field {} FIELD_1[17:17] = 0x0;
        field {} FIELD_2[16:14] = 0x0;
        field {} FIELD_3[13:13] = 0x1;
    };
    reg tem_alias_2{
        field {} FIELD_1[17:17] = 0x0;
        field {} FIELD_2[16:14] = 0x0;
        field {} FIELD_3[13:13] = 0x1;
    };
    addrmap flatten_map {
        hj_gendisp = false;
        hj_genslv = false;
        hj_flatten_addrmap = true;

        tem_alias_1 TEM21 @0xc;
        alias TEM21 tem_alias_1 TEM21_alias @0X10c;

        tem_alias_2 TEM22 @0x10;
        alias TEM22 tem_alias_2 TEM22_alias @0X110;
    };
	addrmap {
		hj_gendisp = true;
		hj_flatten_addrmap=false;

		addrmap {
			hj_gendisp = false;
			hj_genslv = true;
			hj_flatten_addrmap = false;
			flatten_map map_11[5];
			flatten_map map_12[10];
		} slv_map;
	} disp_map;
	// debug registers implemented in regmst, please don't touch it and keep this level clean
	db_regs db_regs %= 0x1000;
};