reg shared_tem{
	shared;
	name = "SHARED";
	desc = "xxx";
	regwidth = 32;
	field {
		name = "FIELD_1";
		desc = "xxx";
		sw = rw;	
	} FIELD_1[16:14] = 0x0;
};

addrmap test_map_2 {
	shared_tem shared_2;
	shared_2 -> name = "SHARED_IN_TEST_MAP_2";
	shared_2.FIELD_1 -> reset = 0X04;
	shared_2.FIELD_1 -> onread = rset;
	shared_2.FIELD_1 -> onwrite = wzt;
};

addrmap test_map_3 {
	shared_tem shared_3;
	shared_3 -> name = "SHARED_IN_TEST_MAP_3";
	shared_3.FIELD_1 -> reset = 0X07;
	shared_3.FIELD_1 -> sw = r;
	shared_3.FIELD_1 -> onread = rclr;
};