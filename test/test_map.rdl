// generated from Excel Worksheet specification: test_map_1.xlsx
addrmap test_map_1 {
	hj_genrtl = true;

	signal {
		name = "sync_rst_signal_1";
		activehigh;
		sync;
	} sync_rst_local_1;

	signal {
		name = "sync_rst_signal_2";
		activehigh;
		sync;
	} sync_rst_local_2;

	reg tem_alias_1{
		name = "TEM21";
		desc = "xxx";
		regwidth = 32;

		field {
			name = "FIELD_1";
			desc = "xxx";
			sw = r;
			onread = rclr;
			hj_syncresetsignal = "sync_rst_local_1";
		} FIELD_1[17:17] = 0x0;

		field {
			name = "FIELD_2";
			desc = "xxx";
			sw = rw;
			onread = rset;
			onwrite = woset;
			hj_syncresetsignal = "sync_rst_local_1, sync_rst_local_2";
		} FIELD_2[16:14] = 0x0;

		field {
			name = "FIELD_3";
			desc = "xxx";
			sw = rw;
			onread = rclr;
			onwrite = wot;
		} FIELD_3[13:13] = 0x1;
	} TEM21 @0xc;

	alias TEM21 tem_alias_1 TEM21_alias @0X10c;
	TEM21_alias.FIELD_2 -> onwrite = wzc;

	reg tem_alias_2{
		name = "TEM22";
		desc = "xxx";
		regwidth = 32;

		field {
			name = "FIELD_1";
			desc = "xxx";
			sw = r;
			onread = rclr;
		} FIELD_1[17:17] = 0x0;

		field {
			name = "FIELD_2";
			desc = "xxx";
			sw = rw;
			onread = rset;
			onwrite = woset;
		} FIELD_2[16:14] = 0x0;

		field {
			name = "FIELD_3";
			desc = "xxx";
			sw = rw;
			onread = rclr;
			onwrite = wot;
		} FIELD_3[13:13] = 0x1;

	} TEM22 @0x10;

	alias TEM22 tem_alias_2 TEM22_alias @0X110;
	TEM22_alias.FIELD_2 -> onread = rset;
	TEM22_alias.FIELD_3 -> name = "FIELD_3 ALIAS";

	reg tem_alias_3{
		name = "TEM23";
		desc = "xxx";
		regwidth = 32;

		field {
			name = "FIELD_1";
			desc = "xxx";
			sw = r;
			onread = rclr;
		} FIELD_1[17:17] = 0x0;

		field {
			name = "FIELD_2";
			desc = "xxx";
			sw = rw;
			onread = rset;
			onwrite = woset;
		} FIELD_2[16:14] = 0x0;

		field {
			name = "FIELD_3";
			desc = "xxx";
			sw = rw;
			onread = rclr;
			onwrite = wot;
		} FIELD_3[13:13] = 0x1;
	} TEM23 @0x14;

	alias TEM23 tem_alias_3 TEM23_alias @0X114;
	TEM23_alias.FIELD_2 -> rclr;
};

reg shared_tem{
	shared;
	name = "SHARED";
	desc = "xxx";
	regwidth = 32;
	field {
		name = "FIELD_1";
		desc = "xxx";
		sw = rw;
	} FIELD_1[16:14] = 0x0;
};

addrmap test_map_2 {
	hj_genrtl = false;
	shared_tem shared_2;
	shared_2 -> name = "SHARED_IN_TEST_MAP_2";
	shared_2.FIELD_1 -> onread = rset;
	shared_2.FIELD_1 -> onwrite = wzt;
};

addrmap test_map_3 {
	hj_genrtl = false;
	shared_tem shared_3[5];
	shared_3 -> hdl_path = "shared_3";
	shared_3 -> name = "SHARED_IN_TEST_MAP_3";
	shared_3.FIELD_1 -> sw = r;
	shared_3.FIELD_1 -> onread = rclr;
};

addrmap root_map {
	hdl_path = "regmst_root_map";
	test_map_1 test_map_1_inst;
	test_map_1_inst -> hdl_path = "test_map_1_inst";
	test_map_2 test_map_2_inst;
	test_map_3 test_map_3_inst;
	ipxact_block_example ipxact_block_example_inst;
	ipxact_block_example_inst -> hdl_path = "ipxact_block_example";
};