addrmap test_map_1 {
	hj_gendisp = false;
	hj_genslv = true;
	hj_flatten_addrmap=false;

	signal {
		name = "sync_rst_signal_1";
		activehigh;
		sync;
	} sync_rst_local_1;

	signal {
		name = "sync_rst_signal_2";
		activehigh;
		sync;
	} sync_rst_local_2;

	reg tem_alias_1{
		name = "TEM21";
		desc = "xxx";
		regwidth = 32;

		field {
			name = "FIELD_1";
			desc = "xxx";
			sw = r;
			onread = rclr;
			hj_syncresetsignal = "sync_rst_local_1";
		} FIELD_1[17:17] = 0x0;

		field {
			name = "FIELD_2";
			desc = "xxx";
			sw = rw;
			onread = rset;
			onwrite = woset;
			hj_syncresetsignal = "sync_rst_local_1, sync_rst_local_2";
		} FIELD_2[16:14] = 0x0;

		field {
			name = "FIELD_3";
			desc = "xxx";
			sw = rw;
			onread = rclr;
			onwrite = wot;
		} FIELD_3[13:13] = 0x1;
	} TEM21 @0xc;

	alias TEM21 tem_alias_1 TEM21_alias @0X10c;
	TEM21_alias.FIELD_2 -> onwrite = wzc;

	reg tem_alias_2{
		name = "TEM22";
		desc = "xxx";
		regwidth = 32;

		field {
			name = "FIELD_1";
			desc = "xxx";
			sw = r;
			onread = rclr;
		} FIELD_1[17:17] = 0x0;

		field {
			name = "FIELD_2";
			desc = "xxx";
			sw = rw;
			onread = rset;
			onwrite = woset;
		} FIELD_2[16:14] = 0x0;

		field {
			name = "FIELD_3";
			desc = "xxx";
			sw = rw;
			onread = rclr;
			onwrite = wot;
		} FIELD_3[13:13] = 0x1;

	} TEM22 @0x10;

	alias TEM22 tem_alias_2 TEM22_alias @0X110;
	TEM22_alias.FIELD_2 -> onread = rset;
	TEM22_alias.FIELD_3 -> name = "FIELD_3 ALIAS";

	reg tem_alias_3{
		name = "TEM23";
		desc = "xxx";
		regwidth = 32;

		field {
			name = "FIELD_1";
			desc = "xxx";
			sw = r;
			onread = rclr;
		} FIELD_1[17:17] = 0x0;

		field {
			name = "FIELD_2";
			desc = "xxx";
			sw = rw;
			onread = rset;
			onwrite = woset;
		} FIELD_2[16:14] = 0x0;

		field {
			name = "FIELD_3";
			desc = "xxx";
			sw = rw;
			onread = rclr;
			onwrite = wot;
		} FIELD_3[13:13] = 0x1;
	} TEM23 @0x14;

	alias TEM23 tem_alias_3 TEM23_alias @0X114;
	TEM23_alias.FIELD_2 -> rclr;
};

reg shared_tem{
	shared;
	name = "SHARED";
	desc = "xxx";
	regwidth = 32;
	field {
		name = "FIELD_1";
		desc = "xxx";
		sw = rw;
	} FIELD_1[16:14] = 0x0;
	field {
		name = "FIELD_1";
		desc = "xxx";
		sw = rw;
	} FIELD_2[13:12] = 0x0;
};

addrmap root_map {
	hj_genmst = true;
	hj_flatten_addrmap=false;

	regfile regfile_test{
		reg shared_reg_1{
			shared;
			name = "SHARED";
			desc = "xxx";
			regwidth = 32;
			field {
				name = "FIELD_1";
				desc = "xxx";
				sw = rw;
			} FIELD_1[16:14] = 0x0;
			field {
				name = "FIELD_1";
				desc = "xxx";
				sw = rw;
			} FIELD_2[13:12] = 0x0;
		};
		reg shared_reg_2{
			shared;
			name = "SHARED";
			desc = "xxx";
			regwidth = 32;
			field {
				name = "FIELD_1";
				desc = "xxx";
				sw = rw;
			} FIELD_1[16:14] = 0x0;
			field {
				name = "FIELD_1";
				desc = "xxx";
				sw = rw;
			} FIELD_2[13:12] = 0x0;
		};
		shared_reg_1 shared_reg_1;
		shared_reg_2 shared_reg_2;
	};

	regfile regfile_test2{
		reg shared_reg_1{
			shared;
			name = "SHARED";
			desc = "xxx";
			regwidth = 32;
			field {
				name = "FIELD_1";
				desc = "xxx";
				sw = rw;
			} FIELD_1[16:14] = 0x0;
			field {
				name = "FIELD_1";
				desc = "xxx";
				sw = rw;
			} FIELD_2[13:12] = 0x0;
		};
		reg shared_reg_2{
			shared;
			name = "SHARED";
			desc = "xxx";
			regwidth = 32;
			field {
				name = "FIELD_1";
				desc = "xxx";
				sw = rw;
			} FIELD_1[16:14] = 0x0;
			field {
				name = "FIELD_1";
				desc = "xxx";
				sw = rw;
			} FIELD_2[13:12] = 0x0;
		};
		shared_reg_1 shared_reg_1;
		shared_reg_2 shared_reg_2;
	};

	addrmap test_map_2 {
		hj_gendisp = false;
		hj_genslv = false;
		hj_flatten_addrmap=true;
		regfile_test regfile_test;
	};

	addrmap test_map_3 {
		hj_gendisp = false;
		hj_genslv = false;
		hj_flatten_addrmap=true;
		regfile_test regfile_test;
	};

	addrmap {
		hj_gendisp = true;
		hj_flatten_addrmap=false;
		test_map_1 map_1[3];
		addrmap {
			hj_gendisp = false;
			hj_genslv = true;
			hj_cdc = true;
			hj_flatten_addrmap=false;
			test_map_2 map_2;
			test_map_3 map_3;
		} shared_map;

		// ipxact_block_example ipxact_map;
		// ipxact_map -> hj_use_abs_addr = true;
	} root_map;

	// debug registers implemented in regmst, please don't touch it and keep this level clean
	db_regs db_regs %= 0x1000;
};