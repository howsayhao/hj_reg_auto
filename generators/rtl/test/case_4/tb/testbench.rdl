reg REG_def {
        regwidth = 32;
        field {
            sw = rw;
        } FIELD_0[31:0] = 0xaaaaaaaa;
};

addrmap reg_network {
    hj_gennetwork = true;
    addrmap {
        hj_genmst = true;
        addrmap {
            hj_gendisp = true;
            addrmap {
                hj_genslv = true;
                // implement internal registers
                REG_def REG1_ONWRITE_NA;
                REG_def REG2_ONWRITE_WOCLR, REG3_ONWRITE_WOSET, REG4_ONWRITE_WOT;
                REG_def REG5_ONWRITE_WZS, REG6_ONWRITE_WZC, REG7_ONWRITE_WZT;
                REG2_ONWRITE_WOCLR.FIELD_0 -> onwrite = woclr;
                REG3_ONWRITE_WOSET.FIELD_0 -> onwrite = woset;
                REG4_ONWRITE_WOT.FIELD_0 -> onwrite = wot;
                REG5_ONWRITE_WZS.FIELD_0 -> onwrite = wzs;
                REG6_ONWRITE_WZC.FIELD_0 -> onwrite = wzc;
                REG7_ONWRITE_WZT.FIELD_0 -> onwrite = wzt;
            } reg_block_1;
        } top;
        db_regs db_regs %=0x1000;
    } top;
};