reg REG_def {
        regwidth = 32;
        field {
            sw = rw;
        } FIELD_0[31:0] = 0xaaaaaaaa;
};

addrmap reg_network {
    hj_gennetwork = true;
    addrmap {
        hj_genmst = true;
        addrmap {
            hj_gendisp = true;
            addrmap {
                hj_genslv = true;
                // implement internal registers
                REG_def REG1_SW_RO, REG2_SW_RW, REG3_SW_RW1, REG4_SW_WO, REG5_SW_W1;
                REG1_SW_RO.FIELD_0 -> sw = r;
                REG3_SW_RW1.FIELD_0 -> sw = rw1;
                REG4_SW_WO.FIELD_0 -> sw = w;
                REG5_SW_W1.FIELD_0 -> sw = w1;
            } reg_block_1;
        } top;
        db_regs db_regs %=0x1000;
    } top;
};
