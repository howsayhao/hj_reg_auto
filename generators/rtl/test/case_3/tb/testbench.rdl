reg REG_def {
		regwidth = 32;
		field {
			sw = rw;
		} FIELD_0[31:0] = 0x0;
};

addrmap reg_top {
	addrmap {
		hj_genrtl = true;

		// implement internal registers
		REG_def REG1_ONREAD_NA, REG2_ONREAD_RCLR, REG3_ONREAD_RSET;
		REG2_ONREAD_RCLR.FIELD_0 -> onread = rclr;
		REG3_ONREAD_RSET.FIELD_0 -> onread = rset;
	} reg_block_1;
};
