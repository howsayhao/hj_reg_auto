reg REG_def {
        regwidth = 32;
        field {
            sw = rw;
        } FIELD_0[31:0] = 0xaaaaaaaa;
};

addrmap reg_network {
    hj_gennetwork = true;
    addrmap {
        hj_genmst = true;
        addrmap {
            hj_gendisp = true;
            addrmap {
                hj_genslv = true;
                // implement internal registers
                REG_def REG1_ONREAD_NA, REG2_ONREAD_RCLR, REG3_ONREAD_RSET;
                REG2_ONREAD_RCLR.FIELD_0 -> onread = rclr;
                REG3_ONREAD_RSET.FIELD_0 -> onread = rset;
            } reg_block_1;
        } top;
        db_regs db_regs %=0x1000;
    } top;
};
