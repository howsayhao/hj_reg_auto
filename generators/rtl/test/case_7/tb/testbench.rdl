reg REG_def {
        regwidth = 32;
        field {
            sw = rw;
        } FIELD_0[31:0] = 0xaaaaaaaa;
};

addrmap reg_network {
    hj_gennetwork = true;
    addrmap {
        hj_genmst = true;
        addrmap {
            hj_gendisp = true;
            addrmap {
                hj_genslv = true;
                // implement internal registers
                REG_def REG1_SRST, REG2_SRST, REG3_SRST;
                REG1_SRST.FIELD_0 -> hj_syncresetsignal = "srst_1,srst_2,srst_3";
                REG1_SRST.FIELD_0 -> reset = 0xdddddddd;
                REG2_SRST.FIELD_0 -> hj_syncresetsignal = "srst_3, srst_4, srst_5";
                REG2_SRST.FIELD_0 -> reset = 0xeeeeeeee;

                REG_def REG4_SWMOD, REG5_SWACC;
                REG4_SWMOD.FIELD_0 -> swmod;
                REG5_SWACC.FIELD_0 -> swacc;
                REG_def REG6_PRECEDENCE_SW, REG7_PRECEDENCE_HW;
                REG6_PRECEDENCE_SW.FIELD_0 -> precedence = sw;
                REG7_PRECEDENCE_HW.FIELD_0 -> precedence = hw;
            } reg_block_1;
        } top;
        db_regs db_regs %=0x1000;
    } top;
};