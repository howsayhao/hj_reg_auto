reg REG_def {
        regwidth = 64;
        field {
            sw = rw;
        } FIELD_0[63:0];
};

mem ext_mem_def {
    mementries = 2;
    memwidth = 128;
};

addrmap reg_network {
    hj_gennetwork = true;
    addrmap {
        hj_genmst = true;
        addrmap {
            hj_gendisp = true;
            addrmap {
                hj_genslv = true;
                hj_cdc = true;
                // implement internal registers
                REG_def REG1;
            } reg_block_1;
            // forward reg_native_if to external memory
            // memwidth=128, datawidth=32, implement snapshot module
            external ext_mem_def ext_mem_1;
            ext_mem_1 -> hj_cdc = true;
        } top;
        db_regs db_regs %=0x1000;
    } top;
};