reg REG_def {
		regwidth = 32;
		field {
			sw = rw;
		} FIELD_0[31:0];
};

mem ext_mem_def {
    mementries = 64;
    memwidth = 128;
};

addrmap reg_top {
	addrmap {
		hj_genrtl = true;

		// implement internal registers
        REG_def REG1;
        // forward reg_native_if to external memory
        // memwidth=128, datawidth=32, implement snapshot module
        external ext_mem_def ext_mem_1;
	} reg_block_1;
};