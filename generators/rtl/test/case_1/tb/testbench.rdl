reg REG_def {
        regwidth = 32;
        field {
            sw = rw;
        } FIELD_0[31:0] = 0x0;
};

addrmap test_1 {
    hj_gendisp = false;
    hj_genslv = true;
    hj_flatten_addrmap = false;

    REG_def REG1, REG2, REG3, REG4;
};

mem ext_mem_def {
    hj_cdc = true;
    mementries = 64;
    memwidth = 32;
};

addrmap reg_network {
    hj_gennetwork = true;
    addrmap {
        hj_genmst = true;
        addrmap {
            hj_gendisp = true;
            addrmap {
                hj_gendisp = true;
                // implement downstream regslv
                test_1 test_11;
                test_11 -> 	hj_cdc = true;
                test_1 test_12;
                test_1 test_13;
                // implement external memory
                external ext_mem_def ext_mem_11;
            } reg_block_1;

            addrmap {
                hj_gendisp = true;
                hj_flatten_addrmap = false;

                // implement downstream regslv
                test_1 test_21;
                // implement external memories
                external ext_mem_def ext_mem_21, ext_mem_22, ext_mem_23;
            } reg_block_2;

            external ext_mem_def ext_mem_in_top;
        } top;
        db_regs db_regs %=0x1000;
    } top;
};
