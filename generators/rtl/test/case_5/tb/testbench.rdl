signal {
    activehigh;
    sync;
} srst_1, srst_2;

// test shared property
reg shared_reg {
    shared;

    field {
        sw = rw;
    } FIELD_0[31:0] = 0xaaaaaaaa;
};

addrmap reg_network {
    hj_gennetwork = true;
    addrmap {
        hj_genmst = true;
        addrmap {
            hj_gendisp = true;
            addrmap {
                hj_genslv = true;
                reg REG1_def {
                    field {
                        sw = rw;
                    } FIELD_0[31:0] = 0xaaaaaaaa;
                } REG1;

                // implement alias register
                alias REG1 REG1_def REG1_alias_1, REG1_alias_2, REG1_alias_3,
                                    REG1_alias_4, REG1_alias_5, REG1_alias_6,
                                    REG1_alias_7, REG1_alias_8, REG1_alias_9,
                                    REG1_alias_10;

                REG1_alias_1.FIELD_0 -> sw = r;
                REG1_alias_2.FIELD_0 -> sw = w;
                REG1_alias_3.FIELD_0 -> onread = rclr;
                REG1_alias_4.FIELD_0 -> onread = rset;
                REG1_alias_5.FIELD_0 -> onwrite = woclr;
                REG1_alias_6.FIELD_0 -> onwrite = woset;
                REG1_alias_7.FIELD_0 -> onwrite = wot;
                REG1_alias_8.FIELD_0 -> onwrite = wzs;
                REG1_alias_9.FIELD_0 -> onwrite = wzc;
                REG1_alias_10.FIELD_0 -> onwrite = wzt;
            } reg_block_1;
        } top;
        db_regs db_regs %=0x1000;
    } top;
};
