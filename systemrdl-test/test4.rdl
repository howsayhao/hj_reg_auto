addrmap addrmap1 {
    name="xxx";
	desc="xxxxxxxx";
    regfile regfile_1 {
        reg reg_1 {
            field {
                hw=rw;
                sw=rw;
            } field_1 = 1'b0;

            field {
                hw=rw;
                sw=rw;
            } field_2 = 1'b0;

            // ......

            field {
                hw=rw;
                sw=rw;
            } field_n = 1'b0;
        };
	    // ......
        reg reg_n {
            field {
                hw=rw;
                sw=rw;
            } field_1 = 1'b0;

            field {
                hw=rw;
                sw=rw;
            } field_2 = 1'b0;

            // ......

            field {
                hw=rw;
                sw=rw;
            } field_n = 1'b0;
        };
    };
    // ......
    regfile regfile_n {
        // ......
    };
    
};

addrmap some_map {
  addressing = fullalign;
  reg { field {} a; } a;              // Address 0
  reg { regwidth=64; field {} a; } b; // Address 8
  reg { field {} a; } c[20];          // Address 0x50 - Element 0
  // Address 0x54 - Element 1
  // Address 0x58 - Element 2
};

