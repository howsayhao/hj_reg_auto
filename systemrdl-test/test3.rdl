regfile fifo_rfile {
  alignment = 8;
  reg {field {} a;} a; // Address of 0
  reg {field {} a;} b; // Address of 8. Normally would have been 4 
};
regfile { 
  external fifo_rfile fifo_a;// Single regfile instance
  external fifo_rfile fifo_b[64]; // Array of regfiles 
	sharedextbus; // Create a common external bus for both of these instantiations
	              // rather than separate external interfaces 
} top_regfile;