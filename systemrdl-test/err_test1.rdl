addrmap some_map{
    default alignment = 8;
    reg DATA_REG{
        desc = "The DATA register is used for sending and receiving data.
        Writing to the register initiates the data transmission, and the byte
        written to the register will be shifted out on the SPI output line.
        Reading the register causes the shift register receive buffer to be read,
        returning the last byte successfully received";
        
        field {
            sw=w; hw=r;
        } WDATA[7:0];
        
        field {
            sw=rss; hw=w;
        } RDATA[7:0];
        
    };
    DATA_REG data1 @0x0;
    DATA_REG data2 @0x5;
};